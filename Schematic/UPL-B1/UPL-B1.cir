.title KiCad schematic
.model __V410 NJF
.model __V409 NJF
.model __V408 NJF
.model __V407 NJF
.model __V404 NJF
.model __V406 NJF
.model __V405 NJF
.model __V307 NJF
.model __V305 NJF
.model __V306 NJF
.model __V304 NJF
.model __V308 NJF
.model __V310 NJF
.model __V309 NJF
.model __V510 NJF
.model __V537 D
.model __V509 D
.model __V504 NJF
.model __V503 NJF
.model __V502 NJF
.model __V501 D
.model __V512 NJF
.model __V20 D
X1 __X1
X4 __X4
X3 __X3
N41 __N41
R430 SIN Net-_C415-Pad1_ 100
C415 Net-_C415-Pad1_ GNDD 330p
C414 GNDD -15V 220uF 35V
C407 -15V GNDD 100n
N42 __N42
C406 +15V GNDD 100n
C404 SIN Net-_V410-S_ 2n2F 100V 1% FKP
JV410 Net-_N42--_ /Integrator_1_&_Loop_Inverter/FRQ_RG1 Net-_V410-S_ __V410
C405 SIN Net-_N42--_ 560p
R425 /Integrator_1_&_Loop_Inverter/FRQ_RG1 GNDD 100k
D41 __D41
R420 +5V Net-_D41-OE_ 1k
C408 GNDD +5V 100n
C403 SIN Net-_V409-S_ 33nF 63V 1% FKP
JV409 Net-_N42--_ /Integrator_1_&_Loop_Inverter/FRQ_RG2 Net-_V409-S_ __V409
R429 Net-_V410-S_ GNDD 10k
R426 /Integrator_1_&_Loop_Inverter/FRQ_RG1 Net-_V410-S_ 100k
R421 /Integrator_1_&_Loop_Inverter/FRQ_RG3 GNDD 100k
R423 /Integrator_1_&_Loop_Inverter/FRQ_RG2 GNDD 100k
JV408 Net-_N42--_ /Integrator_1_&_Loop_Inverter/FRQ_RG3 Net-_V408-S_ __V408
R424 /Integrator_1_&_Loop_Inverter/FRQ_RG2 Net-_V409-S_ 100k
C402 SIN Net-_V408-S_ 330n
R428 Net-_V409-S_ GNDD 10k
R427 Net-_V408-S_ GNDD 10k
R422 /Integrator_1_&_Loop_Inverter/FRQ_RG3 Net-_V408-S_ 100k
R408 Net-_N42--_ Net-_D40-RFB_ 41K7 0.1%
R409 Net-_N42--_ Net-_D40-RFB_ 1Meg
R419 Net-_V407-G_ GNDD 15k
C400 Net-_D40-IOUT1_ Net-_D40-RFB_ 3.9p
R413 Net-_V401-B_ Net-_V405-G_ 15k
R414 Net-_V402-B_ Net-_V406-G_ 15k
JV407 Net-_V403-C_ Net-_V407-G_ Net-_N42--_ __V407
JV404 Net-_N42--_ Net-_V404-G_ Net-_V400-C_ __V404
R412 Net-_V400-B_ Net-_V404-G_ 15k
JV406 Net-_N42--_ Net-_V406-G_ Net-_V402-C_ __V406
JV405 Net-_N42--_ Net-_V405-G_ Net-_V401-C_ __V405
R418 Net-_V406-G_ GNDD 15k
R417 Net-_V405-G_ GNDD 15k
R416 Net-_V404-G_ GNDD 15k
R405 /LOOP Net-_R404-Pad1_ 1.21k
R404 Net-_R404-Pad1_ Net-_V403-C_ 38K8 0.1%
R406 /LOOP Net-_N42--_ 41K7 0.1%
R415 Net-_V403-B_ Net-_V407-G_ 15k
R407 /LOOP Net-_N42--_ 1Meg
V403 __V403
R400 /LOOP Net-_V400-C_ 5K05 0.1%
R401 /LOOP Net-_V400-C_ 511k
R403 /LOOP Net-_V402-C_ 20K 0.1%
V401 __V401
R402 /LOOP Net-_V401-C_ 10K 0.1%
V400 __V400
V402 __V402
R410 +5V Net-_D40-_CLR_ 1k
R411 Net-_D40-STB1_ GNDD 1k
D40 __D40
C401 Net-_N40-COMP_ Net-_N40-C/B_ 3.9p
C409 +15V GNDD 100n
C410 -15V GNDD 100n
N40 __N40
P40 __P40
R331 Net-_V312-K_ GNDD 15k
R330 Net-_V313-K_ GNDD 15k
R332 Net-_V311-K_ GNDD 15k
R337 GNDD Net-_V315-B_ 3.32k
V315 __V315
R334 Net-_V316-B_ -15V 7.5k
R336 Net-_V316-B_ Net-_V316-E_ 100k
V316 __V316
R338 GNDD Net-_V316-B_ 3.32k
V314 __V314
R333 Net-_V315-B_ +15V 7.5k
R335 Net-_V315-B_ Net-_V314-A_ 100k
R341 +5V Net-_D32-_CLR_ 1k
C311 Net-_D32-IOUT1_ Net-_D32-RFB_ 3.9p
N35 __N35
P32 __P32
C312 Net-_N35-COMP_ Net-_N35-C/B_ 3.9p
P31 __P31
C319 Net-_C319-Pad1_ /COS 3.3p
R345 /Integrator_1_&_Loop_Inverter/ALC Net-_C319-Pad1_ 47.5k
R329 Net-_V310-S_ GNDD 10k
C304 /COS Net-_V310-S_ 2n2F 100V 1% FKP
R326 Net-_V310-G_ Net-_V310-S_ 100k
R328 Net-_V309-S_ GNDD 10k
C303 /COS Net-_V309-S_ 33nF 63V 1% FKP
R324 Net-_V309-G_ Net-_V309-S_ 100k
C302 /COS Net-_V308-S_ 330n
R347 /LOOP Net-_C321-Pad1_ 100
R343 /Integrator_1_&_Loop_Inverter/ALC Net-_D32-IOUT1_ 121k
C314 -15V GNDD 100n
C310 Net-_N34-COMP_ Net-_N34-C/B_ 3.9p
C321 Net-_C321-Pad1_ GNDD 330p
C313 +15V GNDD 100n
P34 __P34
R339 /LOOP /Integrator_1_&_Loop_Inverter/ALC 4K75 0.1%
C309 /LOOP /Integrator_1_&_Loop_Inverter/ALC 3.9p
N34 __N34
R346 /COS Net-_C320-Pad1_ 100
C320 Net-_C320-Pad1_ GNDD 330p
R340 /Integrator_1_&_Loop_Inverter/ALC /COS 4K75 0.1%
R342 Net-_D32-STB1_ GNDD 1k
D32 __D32
R309 Net-_N32--_ Net-_D30-RFB_ 1Meg
R308 Net-_N32--_ Net-_D30-RFB_ 41K7 0.1%
R319 Net-_V307-G_ GNDD 15k
N31 __N31
R318 Net-_V306-G_ GNDD 15k
P33 __P33
C316 +15V GNDD 100n
N30 __N30
C301 Net-_N30-COMP_ Net-_N30-C/B_ 3.9p
C317 -15V GNDD 100n
D30 __D30
R311 Net-_D30-STB1_ GNDD 1k
R310 +5V Net-_D30-_CLR_ 1k
R302 SIN Net-_V301-C_ 10K 0.1%
P30 __P30
R300 SIN Net-_V300-C_ 5K05 0.1%
R301 SIN Net-_V300-C_ 511k
R307 SIN Net-_N32--_ 1Meg
C300 Net-_D30-IOUT1_ Net-_D30-RFB_ 3.9p
R306 SIN Net-_N32--_ 41K7 0.1%
V302 __V302
R314 Net-_V302-B_ Net-_V306-G_ 15k
JV307 Net-_V303-C_ Net-_V307-G_ Net-_N32--_ __V307
V303 __V303
R315 Net-_V303-B_ Net-_V307-G_ 15k
R304 Net-_R304-Pad1_ Net-_V303-C_ 38K8 0.1%
R303 SIN Net-_V302-C_ 20K 0.1%
R305 SIN Net-_R304-Pad1_ 1.21k
V301 __V301
V300 __V300
JV305 Net-_N32--_ Net-_V305-G_ Net-_V301-C_ __V305
R313 Net-_V301-B_ Net-_V305-G_ 15k
R312 Net-_V300-B_ Net-_V304-G_ 15k
JV306 Net-_N32--_ Net-_V306-G_ Net-_V302-C_ __V306
R316 Net-_V304-G_ GNDD 15k
R317 Net-_V305-G_ GNDD 15k
JV304 Net-_N32--_ Net-_V304-G_ Net-_V300-C_ __V304
R327 Net-_V308-S_ GNDD 10k
R322 Net-_V308-G_ Net-_V308-S_ 100k
C325 GNDD -15V 100uF 25V
N32 __N32
JV308 Net-_N32--_ Net-_V308-G_ Net-_V308-S_ __V308
JV310 Net-_N32--_ Net-_V310-G_ Net-_V310-S_ __V310
JV309 Net-_N32--_ Net-_V309-G_ Net-_V309-S_ __V309
C305 /COS Net-_N32--_ 560p
N33 __N33
R348 -15V -15V 100
R344 Net-_N33E-V-_ -24V 100
C315 GNDD Net-_N33E-V-_ 47uF 50V
C322 GNDD -15V 100uF 25V
R320 +5V Net-_D31-OE_ 1k
D31 __D31
C308 GNDD +5V 100n
R323 Net-_V309-G_ GNDD 100k
R325 Net-_V310-G_ GNDD 100k
V312 __V312
V311 __V311
V313 __V313
R321 Net-_V308-G_ GNDD 100k
C306 +15V GNDD 100n
C307 -15V GNDD 100n
X51 __X51
R510 GNDD Net-_N52-+_ 100
C506 +15V GNDD 100n
C507 -15V GNDD 100n
R511 Net-_N52-+_ Net-_D50-Pad1_ 10k
R543 Net-_N52-V+_ +15V 100
N52 __N52
C523 Net-_N52-V+_ GNDD 2u2F 50V
R522 +5V Net-_D50E-VCC_ 22.1
D50 __D50
C508 Net-_D50E-VCC_ GNDD 10uF 50V
R512 Net-_D50-Pad1_ Net-_D50E-VCC_ 2.21k
V507 __V507
R520 Net-_C509-Pad1_ Net-_V507-E_ 2.21k
V505 __V505
C504 Net-_N53B-+_ Net-_V502-S_ 1nF 100V 1% FKP
R513 Net-_X51-Pin_2_ Net-_N52--_ 10k
C505 Net-_N52--_ GNDD 33p
R514 GNDD Net-_N52--_ 10k
N56 __N56
N55 __N55
N54 __N54
P54 __P54
C510 Net-_N55B-+_ Net-_C510-Pad2_ 15p
C511 Net-_N55B-+_ GNDD 100n
R517 Net-_N55B--_ Net-_V512-G_ 100k
P53 __P53
V511 __V511
JV510 Net-_N55B-+_ Net-_V510-G_ Net-_N53B--_ __V510
N53 __N53
R516 Net-_N53B--_ Net-_V510-G_ 10k
P56 __P56
V506 __V506
R519 Net-_V506-B_ -15V 2.21k
P57 __P57
R518 Net-_V505-B_ -15V 2.21k
V508 __V508
R521 Net-_C510-Pad2_ Net-_V508-E_ 2.21k
DV537 /Level_Control__ALC_/LOFREQ Net-_V537-K_ __V537
R537 Net-_D50-Pad8_ Net-_V537-K_ 562
DV509 GNDD Net-_V509-K_ __V509
N50 __N50
R523 GNDD Net-_V509-K_ 20k
C509 Net-_C509-Pad1_ Net-_V509-K_ 3.3n
R505 Net-_X50-Pin_2_ Net-_N51--_ 4K75 0.1%
N51 __N51
C503 Net-_N51-COMP_ Net-_N51-C/B_ 4.7p
C501 Net-_N51--_ Net-_V504-D_ 15p
R515 Net-_V504-D_ Net-_V504-G_ 10k
JV504 Net-_V504-D_ Net-_V504-G_ Net-_N53B-+_ __V504
JV503 GNDD Net-_V503-G_ Net-_V503-S_ __V503
JV502 GNDD Net-_V502-G_ Net-_V502-S_ __V502
R508 Net-_V503-S_ Net-_V502-S_ 274
C521 Net-_V502-S_ Net-_C509-Pad1_ 8.2p
C522 Net-_C509-Pad1_ GNDD 1p
R509 GNDD Net-_V503-S_ 1.5k
R538 Net-_X50-Pin_2_ Net-_N51--_ 33.2k
X50 __X50
C519 GNDD Net-_C518-Pad1_ 100uF 25V
R501 -15V Net-_C518-Pad1_ 475
R500 Net-_C518-Pad1_ Net-_V500-A_ 475
P55 __P55
R502 Net-_V500-A_ Net-_N51--_ 7.68k
C518 Net-_C518-Pad1_ GNDD 100n
R504 Net-_N51--_ Net-_V504-D_ 20k
V500 GNDD Net-_V500-A_ DC 1.827N
C520 Net-_N51--_ GNDD 27p
C500 Net-_N51--_ Net-_N51--_ 14pF-1pF
R503 Net-_V501-A_ Net-_V504-D_ 4K75 0.1%
DV501 Net-_V501-A_ Net-_N51--_ __V501
C502 Net-_X50-Pin_2_ Net-_N51--_ 33p
R507 GNDD Net-_V503-G_ 15k
R506 GNDD Net-_V502-G_ 15k
R532 Net-_D51-KXY+_ Net-_N56A--_ 3.92k
R534 Net-_N56A--_ Net-_X52-Pin_1_ 10k
R533 Net-_D51-KXY-_ Net-_N56A-+_ 3.92k
R535 GNDD Net-_N56A-+_ 10k
R529 GNDD Net-_D51-Pad13_ 7.5k
D51 __D51
R528 GNDD Net-_D51-Pad3_ 5.62k
C517 -15V GNDD 100n
R536 Net-_X52-Pin_2_ /Integrator_1_&_Loop_Inverter/ALC 47.5k
X52 __X52
V515 __V515
R541 Net-_D51-VX-_ SIN 4K75 0.1%
R525 Net-_D51-RX-Pad10_ Net-_D51-RX-Pad11_ 2.43k
R542 Net-_D51-VX-_ GNDD 475
R540 Net-_D51-VY+_ Net-_N55B--_ 2.74k
V513 __V513
V514 __V514
C515 Net-_D51-VCC_ GNDD 100n
R526 Net-_D51-RY-Pad6_ Net-_D51-RY-Pad5_ 1.62k
C516 +15V GNDD 100n
R530 Net-_D51-KXY+_ +15V 2.21k
R531 Net-_D51-KXY-_ +15V 2.21k
V516 Net-_D51-VCC_ GNDD DC B7V5
R527 Net-_D51-VCC_ +15V 1k
P58 __P58
JV512 Net-_N55B--_ Net-_V512-G_ Net-_V512-S_ __V512
R524 Net-_V512-S_ Net-_N54B--_ 2k
C512 Net-_C512-Pad1_ Net-_N54B--_ 150n
R539 Net-_C512-Pad1_ Net-_D51-VY-_ 2.74k
C209 +5V GNDD 100n
DV20 Net-_V20-A_ +5V __V20
K2 __K2
V21 __V21
R202 Net-_D21-QP0_ Net-_V21-B_ 10k
D20 __D20
R207 GNDD Net-_D20-Pad12_ 1k
C203 +15V GNDD 100uF 25V
R203 +15V +15V 10
C202 GNDD -15V 100uF 25V
C200 +5V GNDD 100uF 25V
C201 +15V GNDD 100uF 25V
D21 __D21
R206 +5V Net-_D20-Pad1_ 1k
C205 +5V GNDD 100uF 25V
C207 +5V GNDD 100n
C208 +5V GNDD 100n
R201 +2V5 GNDD 10k
C206 +2V5 GNDD 100n
P20 __P20
R204 -15V 15V 10
R205 +5V +5V 10
C204 GNDD 15V 100uF 25V
R200 +5V +2V5 10k
C211 +15V GNDD 100n
C215 Net-_D22-IOUT1_ Net-_D22-RFB_ 3.9p
D22 __D22
N20 __N20
P21 __P21
C216 Net-_N20-COMP_ Net-_N20-C/B_ 3.9p
C212 -15V GNDD 100n
R209 GNDD Net-_D22-STB1_ 1k
R211 GNDD Net-_D23-_CE_ 1k
R212 GNDD Net-_D23-D1_ 1k
R210 +5V Net-_D23-D0_ 1k
C210 +5V GNDD 100n
D23 __D23
X2 __X2
R215 Net-_X2-Pin_2_ Net-_K2-Pad11_ 47.5
R208 Net-_D22-_STB3_ +5V 1k
.end
